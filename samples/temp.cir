* Single Transistor PVT Test - PMOS_OFF

.include "32nm_HP.pm"

* Options strictly as required by specification

.options gmin=1e-18 abstol=1e-18 reltol=1e-6 vntol=1e-9

* Independent Voltage Sources for all terminals

Vd d 0 DC 0.14626751687851275

Vg g 0 DC 0.849085272726781

Vs s 0 DC 0.21855283326679115

Vb b 0 DC 0.849085272726781

* Device Under Test

M1 d g s b pmos W=7.059145422925076e-08 L=1.6e-08 TEMP=102.18160721905511

.control

dc Vd 0.14626751687851275 0.14626751687851275 1

print i(Vd) i(Vg) i(Vs) i(Vb)

.endc

.end
